** sch_path: /home/lab-user/untitled-1.sch
**.subckt untitled-1
M1 Vout Vin VDD irf5305
M2 Vout Vin GND irf540
V1 VDD GND 1.8
V2 Vin GND 1.8
**** begin user architecture code

.dc V2 0 1.8 0.01
.save all

 .MODEL IRF5305 PMOS (VT0=-0.7 KP=2e-3 L=1u W=100u)
.MODEL IRF540 NMOS (VT0=0.7 KP=4e-3 L=1u W=100u)

**** end user architecture code
**.ends
.GLOBAL GND
.GLOBAL VDD
.end
